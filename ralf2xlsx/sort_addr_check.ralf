# ---------------------------------------------------------------------------
# sort_addr_check.ralf -- fixture for CI: blocks declared out of address
# order, and of mixed content (register / memory-only / genuinely empty),
# so --sort addr has something real to prove for all three. Addresses are
# chosen so the default (always-on) CDM address-map keeps them in the same
# relative order: PF = bits[18:16] of the source address, and the target
# layout orders primarily by PF, so a(PF=1) < d(PF=2) < b(PF=3) < e(PF=4)
# < c(PF=5) survives the remap unchanged.
# ---------------------------------------------------------------------------

register r {
   bytes 4;
   field f { bits 32; access rw; }
}

block c {
   bytes 4;
   register r @'h0;
}

block e {
   bytes 4;
}

block a {
   bytes 4;
   register r @'h0;
}

block d {
   bytes 4;
   memory m {
      bits 32;
      size 16;
      access rw;
   }
}

block b {
   bytes 4;
   register r @'h0;
}

system top {
   bytes 4;
   block c @'h50000;
   block e @'h40000;
   block a @'h10000;
   block d @'h20000;
   block b @'h30000;
}
